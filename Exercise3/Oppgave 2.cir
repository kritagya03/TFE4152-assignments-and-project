[aimspice]
[description]
186
Oppgave 2

.include p18_model_card.inc
.include p18_cmos_models_ff.inc

vdd 1 0 dc 1.8

R 1 3 123000

MQ1 3 3 0 0 NMOS W=5u L=1u
MQ2 1 3 0 0 NMOS W=5u L=1u

.plot dc rds(MQ2)
[dc]
1
vdd
0
1.8
0.01
[ana]
1 0
[end]
