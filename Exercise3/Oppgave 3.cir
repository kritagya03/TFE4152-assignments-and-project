[aimspice]
[description]
281
Oppgave 3

.include gpdk90nm_tt.cir

VDD1 1 0 DC 1V
VDD2 2 0 DC 1V
IBIAS 1 3 100U

XMN3 3 3 4 0 NMOS1V W=1u L=0.1u
XMN4 2 3 5 0 NMOS1V W=1u L=0.1u
XMN1 4 4 0 0 NMOS1V W=1u L=0.1u
XMN2 5 4 0 0 NMOS1V W=1u L=0.1u

.plot id(m:mn2:1)
.plot rds(m:mn4:1)
.plot gm(m:mn1:1)
[dc]
1
VDD2
0
1
0.01
[ana]
1 0
[end]
